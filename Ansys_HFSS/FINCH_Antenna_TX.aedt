# Ansys Electronics Desktop project, version 2023.1
project variables:
  $gnd_l = 80mm  # GND Length
  $gnd_w = 100mm  # GND Width
  $substrate_l = 80mm  # Substrate Length
  $substrate_w = 100mm  # Substrate Width
  $substrate_h = 1.6mm  # Substrate Height
  $tx_patch_l = 31.552mm  # TX Patch Length; optimise 29mm..33mm
  $tx_patch_w = 31.275mm  # TX Patch Width; optimise 29mm..33mm
  $tx_pos_x = -0.652fraction  # TX Feed Position (x); optimise -1fraction..0fraction
  $feed_ext_r = 1.8mm  # Coaxial External Radius
  $blinge_r = 1.67mm  # Coaxial Insulator Radius
  $feed_in_r = 0.635mm  # Coaxial Internal Radius
  $tx_tc = 4.305mm  # TX Truncated Corner; optimise 0.1mm..16.5mm
materials:
  FR4_epoxy: permittivity=4.4 dielectric_loss_tangent=0.02
  Teflon (tm): permittivity=2.1 dielectric_loss_tangent=0.001
  pec: conductivity=1e+30
  vacuum: permittivity=1
  Rogers RO3003 (tm): permittivity=3 dielectric_loss_tangent=0.0013

design TCP_Patch (HFSS, HFSS Terminal Network, model units mm)
options: open_region{BoundaryType=0 OpFreq=2.245GHz}
geometry:
  gnd = rectangle(corner=(0mm, 0mm, 0mm), x_size=$gnd_l, y_size=$gnd_w)
  substrate [FR4_epoxy] = box(corner=(0mm, 0mm, 0mm), size=($substrate_l, $substrate_w, $substrate_h))
  coordinate_system TX_Relative = origin=(4cm, 2.5cm, 0mm) x=(1mm, 0mm, 0mm) y=(0mm, 1mm, 0mm)
  tx_patch = rectangle(corner=(- ($tx_patch_l / 2), -($tx_patch_w / 2), $substrate_h), x_size=$tx_patch_l, y_size=$tx_patch_w) in TX_Relative
  tx_feed_ext [pec, oriented by TX_Relative] = cylinder(axis=Z, base_centre=($tx_pos_x * ($tx_patch_l / 2), 0, 0mm), radius=$feed_ext_r, height=-5mm) in TX_Relative
  tx_insulator [Teflon (tm), oriented by TX_Relative] = cylinder(axis=Z, base_centre=($tx_pos_x * ($tx_patch_l / 2), 0, 0mm), radius=$blinge_r, height=-5mm) in TX_Relative
  tx_feed_in [pec, oriented by TX_Relative] = cylinder(axis=Z, base_centre=($tx_pos_x * ($tx_patch_l / 2), 0, 0mm), radius=$feed_in_r, height=-5mm) in TX_Relative
  tx_feed_patch [pec, oriented by TX_Relative] = cylinder(axis=Z, base_centre=($tx_pos_x * ($tx_patch_l / 2), 0, 0mm), radius=$feed_in_r, height=$substrate_h) in TX_Relative
  tx_port [oriented by TX_Relative] = circle(normal=Z, centre=($tx_pos_x * ($tx_patch_l / 2), 0, -5mm), radius=$feed_ext_r) in TX_Relative
  Polyline1 = polyline(z=$substrate_h, xy: (-($tx_patch_l / 2) + $tx_patch_l, - ($tx_patch_w / 2) + $tx_patch_w - $tx_tc) (-($tx_patch_l / 2) + $tx_patch_l, - ($tx_patch_w / 2) + $tx_patch_w) (-($tx_patch_l / 2) + $tx_patch_l - $tx_tc, - ($tx_patch_w / 2) +$tx_patch_w) (-($tx_patch_l / 2) + $tx_patch_l, - ($tx_patch_w / 2) + $tx_patch_w - $tx_tc), closed, covered) in TX_Relative
  Polyline2 = polyline(z=$substrate_h, xy: (- ($tx_patch_l / 2), - ($tx_patch_w / 2)) (- ($tx_patch_l / 2) + $tx_tc, - ($tx_patch_w / 2)) (- ($tx_patch_l / 2), - ($tx_patch_w / 2)  + $tx_tc) (- ($tx_patch_l / 2), - ($tx_patch_w / 2)), closed, covered) in TX_Relative
  tx_patch.subtract(Polyline1, Polyline2)
  RadiatingSurface [vacuum] = region(absolute_offset=44.54343mm on all sides)
  gnd_cut_tx = circle(normal=Z, centre=($tx_pos_x * ($tx_patch_l / 2), 0, 0mm), radius=$feed_ext_r) in TX_Relative
  gnd.subtract(gnd_cut_tx)
boundaries and excitations:
  gnd: Perfect E Objects=gnd
  tx_patch: Perfect E Objects=tx_patch
  AutoOpen1: Radiation Objects=RadiatingSurface
  port_T1: Terminal port=TX_Port Faces=tx_feed_in.face(at (29.714, 25, -5)) TerminalResistance=50ohm
  TX_Port: Lumped Port Faces=tx_port.face LumpedPortType=Terminal Impedance=50ohm
setups:
  TX_Frequency: HfssDriven Frequency=2.245GHz MaxDeltaS=0.01 MaximumPasses=20 MinimumPasses=1 MinimumConvergedPasses=1 PercentRefinement=30 BasisOrder=1 PortAccuracy=2 DrivenSolverType="Direct Solver"
    sweep Sweep: 2GHz to 2.5GHz, 401 points; Type=Interpolating SaveFields InterpTolerance=0.5 InterpMaxSolns=250 PassivityErrorTolerance=0.0001
source amplitudes:
  TX_Port:1: 1V 0deg
optimetrics:
  MOGA: Optimization disabled Optimizer="DX MOGA" AnalysisStopOptions{StopForNumIteration MaxNumIteration=1100 MinNumIteration=10} CostFuncNormType=L2 Acceptable_Cost=0 Noise=0.0001 UpdateDesignWhenDone
    vary $tx_patch_l: Min=29mm Max=33mm MinStep=0.09856mm MaxStep=0.9856mm MinFocus=29mm MaxFocus=33mm start=31.58mm
    vary $tx_patch_w: Min=29mm Max=33mm MinStep=0.09856mm MaxStep=0.9856mm MinFocus=29mm MaxFocus=33mm start=31.853mm
    vary $tx_pos_x: Min=-1fraction Max=0fraction MinStep=0.004058fraction MaxStep=0.04058fraction MinFocus=-1fraction MaxFocus=0fraction start=-0.5fraction
    vary $tx_tc: Min=0.1mm Max=16.5mm MinStep=0.00873mm MaxStep=0.0873mm MinFocus=0.1mm MaxFocus=16.5mm start=4mm
    goal dB(GainLHCP) >= 2.5 weight 2 on TX_Frequency : LastAdaptive at Theta 0deg, Phi 0deg, Freq 2.245GHz
    goal dB(St(port_T1,port_T1)) <= -10 weight 1 on TX_Frequency : Sweep at Freq 2.2GHz to 2.29GHz
    goal dB(AxialRatioValue) <= 3 weight 2 on TX_Frequency : LastAdaptive at Theta 0deg, Phi 0deg, Freq 2.245GHz
  ASO: Optimization disabled Optimizer="kDX ASO" AnalysisStopOptions{StopForNumIteration MaxNumIteration=68 MinNumIteration=10} CostFuncNormType=L2 Acceptable_Cost=0 Noise=0.0001 UpdateDesignWhenDone
    vary $tx_patch_l: Min=31mm Max=32.5mm MinStep=0.09856mm MaxStep=0.9856mm MinFocus=29mm MaxFocus=33mm start=31.58mm
    vary $tx_patch_w: Min=31mm Max=32.5mm MinStep=0.09856mm MaxStep=0.9856mm MinFocus=29mm MaxFocus=33mm start=31.853mm
    vary $tx_pos_x: Min=-1fraction Max=0fraction MinStep=0.004058fraction MaxStep=0.04058fraction MinFocus=-1fraction MaxFocus=0fraction start=-0.5fraction
    vary $tx_tc: Min=4mm Max=4.8mm MinStep=0.00873mm MaxStep=0.0873mm MinFocus=0.1mm MaxFocus=16.5mm start=4mm
    goal dB(GainLHCP) >= 2.5 weight 2 on TX_Frequency : LastAdaptive at Theta 0deg, Phi 0deg, Freq 2.245GHz
    goal dB(St(port_T1,port_T1)) <= -10 weight 2 on TX_Frequency : Sweep at Freq 2.2GHz to 2.29GHz
    goal dB(AxialRatioValue) <= 3 weight 2 on TX_Frequency : LastAdaptive at Theta 0deg, Phi 0deg, Freq 2.245GHz
radiation setups:
  Infinite Sphere1: Infinite Sphere Theta=-180deg..180deg step 10deg Phi=0deg..360deg step 10deg
reports:
  S11 (dB) vs. Frequency (GHz): dB(St(port_T1,port_T1)) vs Freq on TX_Frequency : Sweep [$tx_patch_l=all $tx_patch_w=all $tx_pos_x=all $tx_tc=all]; markers MX1 at x=2.245e+09, MX2 at x=2.29e+09, MX3 at x=2.2e+09, MY1 at y=-10
  LHCP Directivity (dB) vs. Frequency (GHz): dB(DirLHCP) vs Freq on TX_Frequency : Sweep, Infinite Sphere1 [Phi=0deg Theta=0deg $tx_patch_l=all $tx_patch_w=all $tx_pos_x=all $tx_tc=all]; markers MX1 at x=2.245e+09, MX2 at x=2.29e+09, MX3 at x=2.2e+09, MY1 at y=5
  LHCP Gain (dB) vs. Frequency (GHz): dB(GainLHCP) vs Freq on TX_Frequency : Sweep, Infinite Sphere1 [Phi=0deg Theta=0deg $tx_patch_l=all $tx_patch_w=all $tx_pos_x=all $tx_tc=all]; markers m1 at 2.25GHz, MX1 at x=2.245e+09, MX2 at x=2.29e+09, MX3 at x=2.2e+09, MY1 at y=2.5
  Axial Ratio (dB) vs. Frequency (GHz): dB(AxialRatioValue) vs Freq on TX_Frequency : Sweep, Infinite Sphere1 [Phi=0deg Theta=0deg $tx_patch_l=all $tx_patch_w=all $tx_pos_x=all $tx_tc=all]; markers MX1 at x=2.245e+09, MX2 at x=2.29e+09, MX3 at x=2.2e+09, MY1 at y=3
  LHCP Gain - 3D Polar Plot: dB(GainLHCP) vs Phi, Theta on TX_Frequency : LastAdaptive, Infinite Sphere1 [Freq=2.245GHz $tx_patch_l=31.552mm]
