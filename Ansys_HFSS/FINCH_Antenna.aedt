# Ansys Electronics Desktop project, version 2023.1
project variables:
  $gnd_l = 80mm  # GND Length
  $gnd_w = 100mm  # GND Width
  $substrate_l = 80mm  # Substrate Length
  $substrate_w = 100mm  # Substrate Width
  $substrate_h = 1.6mm  # Substrate Height
  $feed_ext_r = 1.8mm  # Coaxial External Radius
  $blinge_r = 1.67mm  # Coaxial Insulator Radius
  $feed_in_r = 0.635mm  # Coaxial Internal Radius
  $tx_patch_l = 31.552mm  # TX Patch Length
  $tx_patch_w = 31.275mm  # TX Patch Width
  $tx_pos_x = -0.652fraction  # TX Feed Position (x)
  $tx_tc = 4.305mm  # TX Truncated Corner
  $rx_patch_l = 34.204mm  # RX Patch Length
  $rx_patch_w = 34.02mm  # RX Patch Width
  $rx_pos_x = -0.662fraction  # RX Feed Position (x)
  $rx_tc = 4.524mm  # RX Truncated Corner
materials:
  FR4_epoxy: permittivity=4.4 dielectric_loss_tangent=0.02
  Teflon (tm): permittivity=2.1 dielectric_loss_tangent=0.001
  pec: conductivity=1e+30
  vacuum: permittivity=1

design TCP_Patch (HFSS, HFSS Terminal Network, model units mm)
geometry:
  gnd = rectangle(corner=(0mm, 0mm, 0mm), x_size=$gnd_l, y_size=$gnd_w)
  substrate [FR4_epoxy] = box(corner=(0mm, 0mm, 0mm), size=($substrate_l, $substrate_w, $substrate_h))
  coordinate_system TX_Relative = origin=(4cm, 2.5cm, 0mm) x=(1mm, 0mm, 0mm) y=(0mm, 1mm, 0mm)
  tx_patch = rectangle(corner=(- ($tx_patch_l / 2), -($tx_patch_w / 2), $substrate_h), x_size=$tx_patch_l, y_size=$tx_patch_w) in TX_Relative
  tx_feed_ext [pec, oriented by TX_Relative] = cylinder(axis=Z, base_centre=($tx_pos_x * ($tx_patch_l / 2), 0, 0mm), radius=$feed_ext_r, height=-5mm) in TX_Relative
  tx_insulator [Teflon (tm), oriented by TX_Relative] = cylinder(axis=Z, base_centre=($tx_pos_x * ($tx_patch_l / 2), 0, 0mm), radius=$blinge_r, height=-5mm) in TX_Relative
  tx_feed_in [pec, oriented by TX_Relative] = cylinder(axis=Z, base_centre=($tx_pos_x * ($tx_patch_l / 2), 0, 0mm), radius=$feed_in_r, height=-5mm) in TX_Relative
  tx_feed_patch [pec, oriented by TX_Relative] = cylinder(axis=Z, base_centre=($tx_pos_x * ($tx_patch_l / 2), 0, 0mm), radius=$feed_in_r, height=$substrate_h) in TX_Relative
  tx_port [oriented by TX_Relative] = circle(normal=Z, centre=($tx_pos_x * ($tx_patch_l / 2), 0, -5mm), radius=$feed_ext_r) in TX_Relative
  Polyline1 = polyline(z=$substrate_h, xy: (-($tx_patch_l / 2) + $tx_patch_l, - ($tx_patch_w / 2) + $tx_patch_w - $tx_tc) (-($tx_patch_l / 2) + $tx_patch_l, - ($tx_patch_w / 2) + $tx_patch_w) (-($tx_patch_l / 2) + $tx_patch_l - $tx_tc, - ($tx_patch_w / 2) +$tx_patch_w) (-($tx_patch_l / 2) + $tx_patch_l, - ($tx_patch_w / 2) + $tx_patch_w - $tx_tc), closed, covered) in TX_Relative
  Polyline2 = polyline(z=$substrate_h, xy: (- ($tx_patch_l / 2), - ($tx_patch_w / 2)) (- ($tx_patch_l / 2) + $tx_tc, - ($tx_patch_w / 2)) (- ($tx_patch_l / 2), - ($tx_patch_w / 2)  + $tx_tc) (- ($tx_patch_l / 2), - ($tx_patch_w / 2)), closed, covered) in TX_Relative
  tx_patch.subtract(Polyline1, Polyline2)
  coordinate_system RX_Relative = origin=(4cm, 7.5cm, 0mm) x=(1mm, 0mm, 0mm) y=(0mm, 1mm, 0mm)
  rx_feed_ext [pec, oriented by RX_Relative] = cylinder(axis=Z, base_centre=($rx_pos_x * ($rx_patch_l / 2), 0, 0mm), radius=$feed_ext_r, height=-5mm) in RX_Relative
  rx_feed_in [pec, oriented by RX_Relative] = cylinder(axis=Z, base_centre=($rx_pos_x * ($rx_patch_l / 2), 0, 0mm), radius=$feed_in_r, height=-5mm) in RX_Relative
  rx_feed_patch [pec, oriented by RX_Relative] = cylinder(axis=Z, base_centre=($rx_pos_x * ($rx_patch_l / 2), 0, 0mm), radius=$feed_in_r, height=$substrate_h) in RX_Relative
  rx_insulator [Teflon (tm), oriented by RX_Relative] = cylinder(axis=Z, base_centre=($rx_pos_x * ($rx_patch_l / 2), 0, 0mm), radius=$blinge_r, height=-5mm) in RX_Relative
  rx_port [oriented by RX_Relative] = circle(normal=Z, centre=($rx_pos_x * ($rx_patch_l / 2), 0, -5mm), radius=$feed_ext_r) in RX_Relative
  gnd_cut_rx = circle(normal=Z, centre=($rx_pos_x * ($rx_patch_l / 2), 0, 0mm), radius=$feed_ext_r) in RX_Relative
  gnd_cut_tx = circle(normal=Z, centre=($tx_pos_x * ($tx_patch_l / 2), 0, 0mm), radius=$feed_ext_r) in TX_Relative
  gnd.subtract(gnd_cut_rx, gnd_cut_tx)
  rx_patch [oriented by RX_Relative] = rectangle(corner=(- ($rx_patch_l / 2), -($rx_patch_w / 2), $substrate_h), x_size=$rx_patch_l, y_size=$rx_patch_w) in RX_Relative
  Polyline3 = polyline(z=$substrate_h, xy: (- ($rx_patch_l / 2) + $rx_patch_l, - ($rx_patch_w / 2)) (- ($rx_patch_l / 2) + $rx_patch_l, - ($rx_patch_w / 2) + $rx_tc) (- ($rx_patch_l / 2) + $rx_patch_l - $rx_tc, - ($rx_patch_w / 2)) (- ($rx_patch_l / 2) + $rx_patch_l, - ($rx_patch_w / 2)), closed, covered) in RX_Relative
  Polyline4 = polyline(z=$substrate_h, xy: (- ($rx_patch_l / 2), - ($rx_patch_w / 2) + $rx_patch_w) (- ($rx_patch_l / 2) + $rx_tc, - ($rx_patch_w / 2) + $rx_patch_w) (- ($rx_patch_l / 2), - ($rx_patch_w / 2) + $rx_patch_w - $rx_tc) (- ($rx_patch_l / 2), - ($rx_patch_w / 2) + $rx_patch_w), closed, covered) in RX_Relative
  rx_patch.subtract(Polyline3, Polyline4)
  RadiatingSurface [vacuum] = region(absolute_offset=44.54343mm on all sides)
boundaries and excitations:
  gnd: Perfect E Objects=gnd
  tx_patch: Perfect E Objects=tx_patch
  rx_patch: Perfect E Objects=rx_patch
  AutoOpen1: Radiation Objects=RadiatingSurface
  port_T1: Terminal port=TX_Port Faces=tx_feed_in.face(at (29.714, 25, -5)) TerminalResistance=50ohm
  port_T2: Terminal port=RX_Port Faces=rx_feed_in.face(at (28.6785, 75, -5)) TerminalResistance=50ohm
  TX_Port: Lumped Port Faces=tx_port.face LumpedPortType=Terminal Impedance=50ohm
  RX_Port: Lumped Port Faces=rx_port.face LumpedPortType=Terminal Impedance=50ohm
setups:
  TX_Frequency: HfssDriven Frequency=2.245GHz MaxDeltaS=0.01 MaximumPasses=20 MinimumPasses=1 MinimumConvergedPasses=1 PercentRefinement=30 disabled BasisOrder=1 PortAccuracy=2 DrivenSolverType="Direct Solver"
    sweep Sweep: 1.9GHz to 2.4GHz, 401 points; Type=Interpolating SaveFields InterpTolerance=0.5 InterpMaxSolns=250 PassivityErrorTolerance=0.0001
  RX_Frequency: HfssDriven Frequency=2.067GHz MaxDeltaS=0.01 MaximumPasses=20 MinimumPasses=1 MinimumConvergedPasses=1 PercentRefinement=30 BasisOrder=1 PortAccuracy=2 DrivenSolverType="Direct Solver"
    sweep Sweep: 1.9GHz to 2.4GHz, 401 points; Type=Interpolating SaveFields InterpTolerance=0.5 InterpMaxSolns=250 PassivityErrorTolerance=0.0001
source amplitudes:
  TX_Port:1: 0V 0deg
  RX_Port:1: 1V 0deg
radiation setups:
  Infinite Sphere1: Infinite Sphere Theta=-180deg..180deg step 10deg Phi=0deg..360deg step 10deg
reports:
  TX Frequency - TX Port S11 (dB) vs. Frequency (GHz): dB(St(port_T1,port_T1)) vs Freq on TX_Frequency : Sweep; markers MX1 at x=2.245e+09, MX3 at x=2.2e+09, MX2 at x=2.29e+09, MY1 at y=0.1
  TX Frequency - RX Port S22 (dB) vs. Frequency (GHz): dB(St(port_T1,port_T2)) vs Freq on TX_Frequency : Sweep; markers MX1 at x=2.067e+09, MX2 at x=2.11e+09, MX3 at x=2.025e+09
  TX Frequency - S12 (dB) vs. Frequency (GHz): dB(St(port_T1,port_T2)) vs Freq on TX_Frequency : Sweep
  TX Frequency - S21 (dB) vs. Frequency (GHz): dB(St(port_T2,port_T1)) vs Freq on TX_Frequency : Sweep
