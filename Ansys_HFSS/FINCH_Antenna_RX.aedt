# Ansys Electronics Desktop project, version 2023.1
project variables:
  $gnd_l = 80mm  # GND Length
  $gnd_w = 100mm  # GND Width
  $substrate_l = 80mm  # Substrate Length
  $substrate_w = 100mm  # Substrate Width
  $substrate_h = 1.6mm  # Substrate Height
  $feed_ext_r = 1.8mm  # Coaxial External Radius
  $blinge_r = 1.67mm  # Coaxial Insulator Radius
  $feed_in_r = 0.635mm  # Coaxial Internal Radius
  $rx_pos_x = -0.662fraction  # RX Feed Position (x); optimise -1fraction..0fraction
  $rx_patch_l = 34.204mm  # RX Patch Length; optimise 32mm..36mm
  $rx_patch_w = 34.02mm  # RX Patch Width; optimise 32mm..36mm
  $rx_tc = 4.524mm  # RX Truncated Corner; optimise 0.1mm..18mm
materials:
  FR4_epoxy: permittivity=4.4 dielectric_loss_tangent=0.02
  Teflon (tm): permittivity=2.1 dielectric_loss_tangent=0.001
  pec: conductivity=1e+30
  vacuum: permittivity=1

design TCP_Patch (HFSS, HFSS Terminal Network, model units mm)
options: open_region{BoundaryType=0 OpFreq=2.067GHz}
geometry:
  substrate [FR4_epoxy] = box(corner=(0mm, 0mm, 0mm), size=($substrate_l, $substrate_w, $substrate_h))
  coordinate_system RX_Relative = origin=(4cm, 7.5cm, 0mm) x=(1mm, 0mm, 0mm) y=(0mm, 1mm, 0mm)
  rx_feed_ext [pec, oriented by RX_Relative] = cylinder(axis=Z, base_centre=($rx_pos_x * ($rx_patch_l / 2), 0, 0mm), radius=$feed_ext_r, height=-5mm) in RX_Relative
  rx_feed_in [pec, oriented by RX_Relative] = cylinder(axis=Z, base_centre=($rx_pos_x * ($rx_patch_l / 2), 0, 0mm), radius=$feed_in_r, height=-5mm) in RX_Relative
  rx_feed_patch [pec, oriented by RX_Relative] = cylinder(axis=Z, base_centre=($rx_pos_x * ($rx_patch_l / 2), 0, 0mm), radius=$feed_in_r, height=$substrate_h) in RX_Relative
  rx_insulator [Teflon (tm), oriented by RX_Relative] = cylinder(axis=Z, base_centre=($rx_pos_x * ($rx_patch_l / 2), 0, 0mm), radius=$blinge_r, height=-5mm) in RX_Relative
  rx_port [oriented by RX_Relative] = circle(normal=Z, centre=($rx_pos_x * ($rx_patch_l / 2), 0, -5mm), radius=$feed_ext_r) in RX_Relative
  rx_patch [oriented by RX_Relative] = rectangle(corner=(- ($rx_patch_l / 2), -($rx_patch_w / 2), $substrate_h), x_size=$rx_patch_l, y_size=$rx_patch_w) in RX_Relative
  Polyline3 = polyline(z=$substrate_h, xy: (- ($rx_patch_l / 2) + $rx_patch_l, - ($rx_patch_w / 2)) (- ($rx_patch_l / 2) + $rx_patch_l, - ($rx_patch_w / 2) + $rx_tc) (- ($rx_patch_l / 2) + $rx_patch_l - $rx_tc, - ($rx_patch_w / 2)) (- ($rx_patch_l / 2) + $rx_patch_l, - ($rx_patch_w / 2)), closed, covered) in RX_Relative
  Polyline4 = polyline(z=$substrate_h, xy: (- ($rx_patch_l / 2), - ($rx_patch_w / 2) + $rx_patch_w) (- ($rx_patch_l / 2) + $rx_tc, - ($rx_patch_w / 2) + $rx_patch_w) (- ($rx_patch_l / 2), - ($rx_patch_w / 2) + $rx_patch_w - $rx_tc) (- ($rx_patch_l / 2), - ($rx_patch_w / 2) + $rx_patch_w), closed, covered) in RX_Relative
  rx_patch.subtract(Polyline3, Polyline4)
  RadiatingSurface [vacuum] = region(absolute_offset=48.379294mm on all sides)
  gnd = rectangle(corner=(0mm, 0mm, 0mm), x_size=$gnd_l, y_size=$gnd_w)
  gnd_cut_rx1 = circle(normal=Z, centre=($rx_pos_x * ($rx_patch_l / 2), 0, 0mm), radius=$feed_ext_r) in RX_Relative
  gnd.subtract(gnd_cut_rx1)
boundaries and excitations:
  rx_patch: Perfect E Objects=rx_patch
  AutoOpen1: Radiation Objects=RadiatingSurface
  gnd1: Perfect E Objects=gnd
  port_T2: Terminal port=RX_Port Faces=rx_feed_in.face(at (28.6785, 75, -5)) TerminalResistance=50ohm
  RX_Port: Lumped Port Faces=rx_port.face LumpedPortType=Terminal Impedance=50ohm
setups:
  RX_Frequency: HfssDriven Frequency=2.067GHz MaxDeltaS=0.01 MaximumPasses=20 MinimumPasses=1 MinimumConvergedPasses=1 PercentRefinement=30 BasisOrder=1 PortAccuracy=2 DrivenSolverType="Direct Solver"
    sweep Sweep: 1.9GHz to 2.25GHz, 401 points; Type=Interpolating SaveFields InterpTolerance=0.5 InterpMaxSolns=250 PassivityErrorTolerance=0.0001
source amplitudes:
  RX_Port:1: 1V 0deg
optimetrics:
  MOGA: Optimization disabled Optimizer="DX MOGA" AnalysisStopOptions{StopForNumIteration MaxNumIteration=1100 MinNumIteration=10} CostFuncNormType=L2 Acceptable_Cost=0 Noise=0.0001 UpdateDesignWhenDone
    goal dB(St(port_T2,port_T2)) <= -10 weight 1 on RX_Frequency : Sweep at Freq 2.025GHz to 2.11GHz
    goal dB(GainRHCP) >= 2.5 weight 2 on RX_Frequency : LastAdaptive at Theta 0deg, Phi 0deg, Freq 2.067GHz
    goal dB(AxialRatioValue) <= 3 weight 2 on RX_Frequency : LastAdaptive at Theta 0deg, Phi 0deg, Freq 2.067GHz
  ASO: Optimization disabled Optimizer="kDX ASO" AnalysisStopOptions{StopForNumIteration MaxNumIteration=68 MinNumIteration=10} CostFuncNormType=L2 Acceptable_Cost=0 Noise=0.0001 UpdateDesignWhenDone
    vary $rx_patch_l: Min=33.9mm Max=34.5mm MinStep=0.34342mm MaxStep=3.4342mm MinFocus=32mm MaxFocus=36mm start=34.204042mm
    vary $rx_patch_w: Min=33.9mm Max=34.5mm MinStep=0.34596mm MaxStep=3.4596mm MinFocus=32mm MaxFocus=36mm start=34.020331mm
    vary $rx_pos_x: Min=-0.75fraction Max=-0.5fraction MinStep=0.02fraction MaxStep=0.2fraction MinFocus=-1fraction MaxFocus=0fraction start=-0.66231858fraction
    vary $rx_tc: Min=4mm Max=5mm MinStep=0.04323mm MaxStep=0.4323mm MinFocus=0.1mm MaxFocus=18mm start=4.5236099mm
    goal dB(St(port_T2,port_T2)) <= -10 weight 2 on RX_Frequency : Sweep at Freq 2.025GHz to 2.11GHz
    goal dB(GainRHCP) >= 2.5 weight 2 on RX_Frequency : LastAdaptive at Theta 0deg, Phi 0deg, Freq 2.067GHz
    goal dB(AxialRatioValue) <= 3 weight 2 on RX_Frequency : LastAdaptive at Theta 0deg, Phi 0deg, Freq 2.067GHz
radiation setups:
  Infinite Sphere1: Infinite Sphere Theta=-180deg..180deg step 10deg Phi=0deg..360deg step 10deg
reports:
  S22 (dB) vs. Frequency (GHz): dB(St(port_T2,port_T2)) vs Freq on RX_Frequency : Sweep [$rx_pos_x=all $rx_patch_l=34.204mm $rx_patch_w=all $rx_tc=all]; markers MX1 at x=2.067e+09, MX2 at x=2.11e+09, MX3 at x=2.025e+09, MY1 at y=-10
  RHCP Directivity (dB) vs. Frequency (GHz): dB(DirRHCP) vs Freq on RX_Frequency : Sweep, Infinite Sphere1 [Phi=0deg Theta=0deg $rx_pos_x=all $rx_patch_l=34.204mm $rx_patch_w=all $rx_tc=all]; markers MX1 at x=2.067e+09, MX2 at x=2.11e+09, MX3 at x=2.025e+09, MY1 at y=5
  RHCP Gain (dB) vs. Frequency (GHz): dB(GainRHCP) vs Freq on RX_Frequency : Sweep, Infinite Sphere1 [Phi=0deg Theta=0deg $rx_pos_x=all $rx_patch_l=34.204mm $rx_patch_w=all $rx_tc=all]; markers MX1 at x=2.067e+09, MX2 at x=2.11e+09, MX3 at x=2.025e+09, MY1 at y=2.5
  Axial Ratio (dB) vs. Frequency (GHz): dB(AxialRatioValue) vs Freq on RX_Frequency : Sweep, Infinite Sphere1 [Phi=0deg Theta=0deg $rx_pos_x=all $rx_patch_l=34.204mm $rx_patch_w=all $rx_tc=all]; markers MX1 at x=2.067e+09, MX2 at x=2.11e+09, MX3 at x=2.025e+09, MY1 at y=3
